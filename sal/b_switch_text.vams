`include "disciplines.vams"

module b_switch_text (
  out,
  vss,
  CK,
  vdd,
  in,
  nCK
);
  inout vdd;
  electrical vdd;
  inout vss;
  electrical vss;
  input nCK;
  logic nCK;
  input CK;
  logic CK;
  input in;
  electrical in;
  output out;
  electrical out;

  wire net1, net2, net3, net5;
  electrical net4;

  sg13_hv_nmos #(.w(20u), .l(0.45u), .ng(10), .m(1), .mm_ok(1))
    M1(out, net2, in, vss);
  sg13_hv_pmos #(.w(0.3u), .l(0.4u), .ng(1), .m(1), .mm_ok(1))
    M2(net2, net1, net3, net3);
  sg13_hv_nmos #(.w(0.3u), .l(0.45u), .ng(1), .m(1), .mm_ok(1))
    M3(in, net2, net4, vss);
  sg13_hv_nmos #(.w(0.3u), .l(0.45u), .ng(1), .m(1), .mm_ok(1))
    M4(net5, CK, vss, vss);
  sg13_hv_pmos #(.w(0.3u), .l(0.4u), .ng(1), .m(1), .mm_ok(1))
    M5(net3, net2, vdd, net3);
  sg13_hv_nmos #(.w(0.3u), .l(0.45u), .ng(1), .m(1), .mm_ok(1))
    M6(net4, CK, vss, vss);
  sg13_hv_nmos #(.w(0.3u), .l(0.45u), .ng(1), .m(1), .mm_ok(1))
    Ma(net1, nCK, net4, vss);
  sg13_hv_pmos #(.w(0.3u), .l(0.4u), .ng(1), .m(1), .mm_ok(1))
    Mb(net1, nCK, vdd, vdd);
  sg13_hv_nmos #(.w(0.3u), .l(0.45u), .ng(1), .m(1), .mm_ok(1))
    Ma1(net1, net2, net4, vss);
  sg13_hv_nmos #(.w(0.3u), .l(0.45u), .ng(1), .m(1), .mm_ok(1))
    M8(net2, vdd, net5, vss);
  cap_cmim #(.w(7.0e-6), .l(7.0e-6), .m(1), .mm_ok(1))
    C1(net3, net4);
endmodule
