** sch_path: /home/herman/tools/xschem/xschem_library/ngspice_verilog_cosim/sar_adc.sch
**.subckt sar_adc INPUT VREF START VALID D5,D4,D3,D2,D1,D0 CLK
*.ipin INPUT
*.ipin VREF
*.ipin START
*.opin VALID
*.ipin CLK
*.opin D5,D4,D3,D2,D1,D0
CLAST TEST_V 0 '1p / 32' m=1
ACOMP [ %vd(TEST_V VREF) ] [ COMP ] comparator
XSAMPLE INPUT IIN SAMPLE VREF tgate
R1 IIN TEST_V 1k m=1
ADUT [ CLK COMP START ] [ SAMPLE VALID ~D5 ~D4 ~D3 ~D2 ~D1 ~D0 ] dut
A1 [ COMP ] [ COMP_A ] dac_buff
* noconn D[5..0]
* noconn COMP
* noconn %vd(TEST_V VREF)
xb6 TEST_V VREF D5 ccap C = 1p
xb5 TEST_V VREF D4 ccap C = '1p/2'
xb4 TEST_V VREF D3 ccap C = '1p/4'
xb3 TEST_V VREF D2 ccap C = '1p/8'
xb2 TEST_V VREF D1 ccap C = '1p/16'
xb1 TEST_V VREF D0 ccap C = '1p/32'
**.ends

* expanding   symbol:  tgate.sym # of pins=4
** sym_path: /home/herman/tools/xschem/xschem_library/ngspice_verilog_cosim/tgate.sym
** sch_path: /home/herman/tools/xschem/xschem_library/ngspice_verilog_cosim/tgate.sch
.subckt tgate A B CTL VDD
*.ipin CTL
*.iopin B
*.iopin A
*.ipin VDD
SWITCH A B CTL 0 TG
* noconn VDD
.ends

* expanding   symbol:  ccap.sym # of pins=3
** sym_path: /home/herman/tools/xschem/xschem_library/ngspice_verilog_cosim/ccap.sym
** sch_path: /home/herman/tools/xschem/xschem_library/ngspice_verilog_cosim/ccap.sch
.subckt ccap IN VCC CTL  C=1p
*.ipin IN
*.ipin VCC
*.ipin CTL
XINV CTL TAIL VCC ainv
CB IN TAIL c='C' m=1
.ends

* expanding   symbol:  ainv.sym # of pins=3
** sym_path: /home/herman/tools/xschem/xschem_library/ngspice_verilog_cosim/ainv.sym
** sch_path: /home/herman/tools/xschem/xschem_library/ngspice_verilog_cosim/ainv.sch
.subckt ainv IN OUT VDD
*.ipin IN
*.opin OUT
*.ipin VDD
MN OUT IN 0 0 N1
MP OUT IN VDD VDD P1
.ends

**** begin user architecture code
.model dac_buff dac_bridge input_load=1e-15 t_rise=10n t_fall=10n
+ out_low=0 out_high=3.3
.model comparator adc_bridge in_low=0 in_high=0
.MODEL TG SW( VT=1.5 RON=2k )
.model n1 nmos
+  level=2 vto=0.5 kp=24e-6 gamma=0.15 phi=0.65 lambda=0.015 xj=0.5e-6

.model p1 pmos
+  level=2 vto=-0.5 kp=8.5e-6 gamma=0.4 phi=0.65 lambda=0.05 xj=0.5e-6

.model dut d_cosim simulation="ivlng" sim_args=["adc"]
**** end user architecture code
.end
